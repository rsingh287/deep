* ===================================================================
* SPICE Netlist: PIC18F85K22_System_Board
* Generated by Antigravity Local AI PCB Studio
* Ready for verification in LTspice, ngspice, EasyEDA, or Falstad
* ===================================================================
.title PIC18F85K22_System_Board

X_U1 POS_3V3 ICSP_MCLR_VPP OSC_IN OSC_OUT AN0_IN LED_USER ICSP_PGC ICSP_PGD UART_TX UART_RX GPIO_D0 GPIO_D1 GPIO_D2 VCAP_CORE POS_3V3 0 PIC18F85K22_I_PT
X_J1 0 VBUS_5V TYPE_C_16P
X_U2 0 POS_3V3 VBUS_5V AMS1117_3_3
X_J2 ICSP_MCLR_VPP POS_3V3 0 ICSP_PGD ICSP_PGC PICKIT3_ICSP_6P
X_Y1 OSC_IN OSC_OUT 16MHz
C1 OSC_IN 0 22pF
C2 OSC_OUT 0 22pF
C3 VCAP_CORE 0 10uF
C4 POS_3V3 0 100nF
C5 POS_3V3 0 100nF
R1 POS_3V3 MCLR_PULLUP 10k
R2 MCLR_PULLUP ICSP_MCLR_VPP 470
X_SW1 MCLR_PULLUP 0 TACT_SWITCH
R3 LED_USER LED_ANODE 1k
D1 LED_ANODE 0 D_GENERIC
X_J3 POS_3V3 UART_TX UART_RX 0 UART_DEBUG_4P
X_J4 POS_3V3 GPIO_D0 GPIO_D1 GPIO_D2 AN0_IN 0 GPIO_BUS_8P

* Standard Models & Simulation Parameters
.model D_GENERIC D (IS=1e-14 RS=5 N=1.5)
.op
.tran 10u 20m
.end
