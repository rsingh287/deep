* ===================================================================
* SPICE Netlist: DoubleCheck_Test
* Generated by Antigravity Local AI PCB Studio
* Ready for verification in LTspice, ngspice, EasyEDA, or Falstad
* ===================================================================
.title DoubleCheck_Test

X_J1 USB_CC1 USB_CC2 0 VBUS_5V TYPE_C_16P
X_U1 0 POS_3V3 VBUS_5V AMS1117_3_3
C1 VBUS_5V 0 10uF
C2 POS_3V3 0 22uF
R1 USB_CC1 0 5.1k
R2 USB_CC2 0 5.1k
R3 POS_3V3 LED_NODE 1k
D1 LED_NODE 0 D_GENERIC
X_J2 POS_3V3 POS_3V3 0 0 CONN_HEADER_4P

* Standard Models & Simulation Parameters
.model D_GENERIC D (IS=1e-14 RS=5 N=1.5)
.op
.tran 10u 20m
.end
